* 16x16 on-chip power grid, 4 supply pads, 50 uA load per node (IR-drop analysis). Regenerate larger ones with tools/gen_grid.py
VDD vdd 0 DC 1.0
RPAD0 vdd n0_0 0.05
RPAD1 vdd n0_15 0.05
RPAD2 vdd n15_0 0.05
RPAD3 vdd n15_15 0.05
RH0_0 n0_0 n0_1 0.5
RV0_0 n0_0 n1_0 0.5
I0_0 n0_0 0 DC 50u
RH0_1 n0_1 n0_2 0.5
RV0_1 n0_1 n1_1 0.5
I0_1 n0_1 0 DC 50u
RH0_2 n0_2 n0_3 0.5
RV0_2 n0_2 n1_2 0.5
I0_2 n0_2 0 DC 50u
RH0_3 n0_3 n0_4 0.5
RV0_3 n0_3 n1_3 0.5
I0_3 n0_3 0 DC 50u
RH0_4 n0_4 n0_5 0.5
RV0_4 n0_4 n1_4 0.5
I0_4 n0_4 0 DC 50u
RH0_5 n0_5 n0_6 0.5
RV0_5 n0_5 n1_5 0.5
I0_5 n0_5 0 DC 50u
RH0_6 n0_6 n0_7 0.5
RV0_6 n0_6 n1_6 0.5
I0_6 n0_6 0 DC 50u
RH0_7 n0_7 n0_8 0.5
RV0_7 n0_7 n1_7 0.5
I0_7 n0_7 0 DC 50u
RH0_8 n0_8 n0_9 0.5
RV0_8 n0_8 n1_8 0.5
I0_8 n0_8 0 DC 50u
RH0_9 n0_9 n0_10 0.5
RV0_9 n0_9 n1_9 0.5
I0_9 n0_9 0 DC 50u
RH0_10 n0_10 n0_11 0.5
RV0_10 n0_10 n1_10 0.5
I0_10 n0_10 0 DC 50u
RH0_11 n0_11 n0_12 0.5
RV0_11 n0_11 n1_11 0.5
I0_11 n0_11 0 DC 50u
RH0_12 n0_12 n0_13 0.5
RV0_12 n0_12 n1_12 0.5
I0_12 n0_12 0 DC 50u
RH0_13 n0_13 n0_14 0.5
RV0_13 n0_13 n1_13 0.5
I0_13 n0_13 0 DC 50u
RH0_14 n0_14 n0_15 0.5
RV0_14 n0_14 n1_14 0.5
I0_14 n0_14 0 DC 50u
RV0_15 n0_15 n1_15 0.5
I0_15 n0_15 0 DC 50u
RH1_0 n1_0 n1_1 0.5
RV1_0 n1_0 n2_0 0.5
I1_0 n1_0 0 DC 50u
RH1_1 n1_1 n1_2 0.5
RV1_1 n1_1 n2_1 0.5
I1_1 n1_1 0 DC 50u
RH1_2 n1_2 n1_3 0.5
RV1_2 n1_2 n2_2 0.5
I1_2 n1_2 0 DC 50u
RH1_3 n1_3 n1_4 0.5
RV1_3 n1_3 n2_3 0.5
I1_3 n1_3 0 DC 50u
RH1_4 n1_4 n1_5 0.5
RV1_4 n1_4 n2_4 0.5
I1_4 n1_4 0 DC 50u
RH1_5 n1_5 n1_6 0.5
RV1_5 n1_5 n2_5 0.5
I1_5 n1_5 0 DC 50u
RH1_6 n1_6 n1_7 0.5
RV1_6 n1_6 n2_6 0.5
I1_6 n1_6 0 DC 50u
RH1_7 n1_7 n1_8 0.5
RV1_7 n1_7 n2_7 0.5
I1_7 n1_7 0 DC 50u
RH1_8 n1_8 n1_9 0.5
RV1_8 n1_8 n2_8 0.5
I1_8 n1_8 0 DC 50u
RH1_9 n1_9 n1_10 0.5
RV1_9 n1_9 n2_9 0.5
I1_9 n1_9 0 DC 50u
RH1_10 n1_10 n1_11 0.5
RV1_10 n1_10 n2_10 0.5
I1_10 n1_10 0 DC 50u
RH1_11 n1_11 n1_12 0.5
RV1_11 n1_11 n2_11 0.5
I1_11 n1_11 0 DC 50u
RH1_12 n1_12 n1_13 0.5
RV1_12 n1_12 n2_12 0.5
I1_12 n1_12 0 DC 50u
RH1_13 n1_13 n1_14 0.5
RV1_13 n1_13 n2_13 0.5
I1_13 n1_13 0 DC 50u
RH1_14 n1_14 n1_15 0.5
RV1_14 n1_14 n2_14 0.5
I1_14 n1_14 0 DC 50u
RV1_15 n1_15 n2_15 0.5
I1_15 n1_15 0 DC 50u
RH2_0 n2_0 n2_1 0.5
RV2_0 n2_0 n3_0 0.5
I2_0 n2_0 0 DC 50u
RH2_1 n2_1 n2_2 0.5
RV2_1 n2_1 n3_1 0.5
I2_1 n2_1 0 DC 50u
RH2_2 n2_2 n2_3 0.5
RV2_2 n2_2 n3_2 0.5
I2_2 n2_2 0 DC 50u
RH2_3 n2_3 n2_4 0.5
RV2_3 n2_3 n3_3 0.5
I2_3 n2_3 0 DC 50u
RH2_4 n2_4 n2_5 0.5
RV2_4 n2_4 n3_4 0.5
I2_4 n2_4 0 DC 50u
RH2_5 n2_5 n2_6 0.5
RV2_5 n2_5 n3_5 0.5
I2_5 n2_5 0 DC 50u
RH2_6 n2_6 n2_7 0.5
RV2_6 n2_6 n3_6 0.5
I2_6 n2_6 0 DC 50u
RH2_7 n2_7 n2_8 0.5
RV2_7 n2_7 n3_7 0.5
I2_7 n2_7 0 DC 50u
RH2_8 n2_8 n2_9 0.5
RV2_8 n2_8 n3_8 0.5
I2_8 n2_8 0 DC 50u
RH2_9 n2_9 n2_10 0.5
RV2_9 n2_9 n3_9 0.5
I2_9 n2_9 0 DC 50u
RH2_10 n2_10 n2_11 0.5
RV2_10 n2_10 n3_10 0.5
I2_10 n2_10 0 DC 50u
RH2_11 n2_11 n2_12 0.5
RV2_11 n2_11 n3_11 0.5
I2_11 n2_11 0 DC 50u
RH2_12 n2_12 n2_13 0.5
RV2_12 n2_12 n3_12 0.5
I2_12 n2_12 0 DC 50u
RH2_13 n2_13 n2_14 0.5
RV2_13 n2_13 n3_13 0.5
I2_13 n2_13 0 DC 50u
RH2_14 n2_14 n2_15 0.5
RV2_14 n2_14 n3_14 0.5
I2_14 n2_14 0 DC 50u
RV2_15 n2_15 n3_15 0.5
I2_15 n2_15 0 DC 50u
RH3_0 n3_0 n3_1 0.5
RV3_0 n3_0 n4_0 0.5
I3_0 n3_0 0 DC 50u
RH3_1 n3_1 n3_2 0.5
RV3_1 n3_1 n4_1 0.5
I3_1 n3_1 0 DC 50u
RH3_2 n3_2 n3_3 0.5
RV3_2 n3_2 n4_2 0.5
I3_2 n3_2 0 DC 50u
RH3_3 n3_3 n3_4 0.5
RV3_3 n3_3 n4_3 0.5
I3_3 n3_3 0 DC 50u
RH3_4 n3_4 n3_5 0.5
RV3_4 n3_4 n4_4 0.5
I3_4 n3_4 0 DC 50u
RH3_5 n3_5 n3_6 0.5
RV3_5 n3_5 n4_5 0.5
I3_5 n3_5 0 DC 50u
RH3_6 n3_6 n3_7 0.5
RV3_6 n3_6 n4_6 0.5
I3_6 n3_6 0 DC 50u
RH3_7 n3_7 n3_8 0.5
RV3_7 n3_7 n4_7 0.5
I3_7 n3_7 0 DC 50u
RH3_8 n3_8 n3_9 0.5
RV3_8 n3_8 n4_8 0.5
I3_8 n3_8 0 DC 50u
RH3_9 n3_9 n3_10 0.5
RV3_9 n3_9 n4_9 0.5
I3_9 n3_9 0 DC 50u
RH3_10 n3_10 n3_11 0.5
RV3_10 n3_10 n4_10 0.5
I3_10 n3_10 0 DC 50u
RH3_11 n3_11 n3_12 0.5
RV3_11 n3_11 n4_11 0.5
I3_11 n3_11 0 DC 50u
RH3_12 n3_12 n3_13 0.5
RV3_12 n3_12 n4_12 0.5
I3_12 n3_12 0 DC 50u
RH3_13 n3_13 n3_14 0.5
RV3_13 n3_13 n4_13 0.5
I3_13 n3_13 0 DC 50u
RH3_14 n3_14 n3_15 0.5
RV3_14 n3_14 n4_14 0.5
I3_14 n3_14 0 DC 50u
RV3_15 n3_15 n4_15 0.5
I3_15 n3_15 0 DC 50u
RH4_0 n4_0 n4_1 0.5
RV4_0 n4_0 n5_0 0.5
I4_0 n4_0 0 DC 50u
RH4_1 n4_1 n4_2 0.5
RV4_1 n4_1 n5_1 0.5
I4_1 n4_1 0 DC 50u
RH4_2 n4_2 n4_3 0.5
RV4_2 n4_2 n5_2 0.5
I4_2 n4_2 0 DC 50u
RH4_3 n4_3 n4_4 0.5
RV4_3 n4_3 n5_3 0.5
I4_3 n4_3 0 DC 50u
RH4_4 n4_4 n4_5 0.5
RV4_4 n4_4 n5_4 0.5
I4_4 n4_4 0 DC 50u
RH4_5 n4_5 n4_6 0.5
RV4_5 n4_5 n5_5 0.5
I4_5 n4_5 0 DC 50u
RH4_6 n4_6 n4_7 0.5
RV4_6 n4_6 n5_6 0.5
I4_6 n4_6 0 DC 50u
RH4_7 n4_7 n4_8 0.5
RV4_7 n4_7 n5_7 0.5
I4_7 n4_7 0 DC 50u
RH4_8 n4_8 n4_9 0.5
RV4_8 n4_8 n5_8 0.5
I4_8 n4_8 0 DC 50u
RH4_9 n4_9 n4_10 0.5
RV4_9 n4_9 n5_9 0.5
I4_9 n4_9 0 DC 50u
RH4_10 n4_10 n4_11 0.5
RV4_10 n4_10 n5_10 0.5
I4_10 n4_10 0 DC 50u
RH4_11 n4_11 n4_12 0.5
RV4_11 n4_11 n5_11 0.5
I4_11 n4_11 0 DC 50u
RH4_12 n4_12 n4_13 0.5
RV4_12 n4_12 n5_12 0.5
I4_12 n4_12 0 DC 50u
RH4_13 n4_13 n4_14 0.5
RV4_13 n4_13 n5_13 0.5
I4_13 n4_13 0 DC 50u
RH4_14 n4_14 n4_15 0.5
RV4_14 n4_14 n5_14 0.5
I4_14 n4_14 0 DC 50u
RV4_15 n4_15 n5_15 0.5
I4_15 n4_15 0 DC 50u
RH5_0 n5_0 n5_1 0.5
RV5_0 n5_0 n6_0 0.5
I5_0 n5_0 0 DC 50u
RH5_1 n5_1 n5_2 0.5
RV5_1 n5_1 n6_1 0.5
I5_1 n5_1 0 DC 50u
RH5_2 n5_2 n5_3 0.5
RV5_2 n5_2 n6_2 0.5
I5_2 n5_2 0 DC 50u
RH5_3 n5_3 n5_4 0.5
RV5_3 n5_3 n6_3 0.5
I5_3 n5_3 0 DC 50u
RH5_4 n5_4 n5_5 0.5
RV5_4 n5_4 n6_4 0.5
I5_4 n5_4 0 DC 50u
RH5_5 n5_5 n5_6 0.5
RV5_5 n5_5 n6_5 0.5
I5_5 n5_5 0 DC 50u
RH5_6 n5_6 n5_7 0.5
RV5_6 n5_6 n6_6 0.5
I5_6 n5_6 0 DC 50u
RH5_7 n5_7 n5_8 0.5
RV5_7 n5_7 n6_7 0.5
I5_7 n5_7 0 DC 50u
RH5_8 n5_8 n5_9 0.5
RV5_8 n5_8 n6_8 0.5
I5_8 n5_8 0 DC 50u
RH5_9 n5_9 n5_10 0.5
RV5_9 n5_9 n6_9 0.5
I5_9 n5_9 0 DC 50u
RH5_10 n5_10 n5_11 0.5
RV5_10 n5_10 n6_10 0.5
I5_10 n5_10 0 DC 50u
RH5_11 n5_11 n5_12 0.5
RV5_11 n5_11 n6_11 0.5
I5_11 n5_11 0 DC 50u
RH5_12 n5_12 n5_13 0.5
RV5_12 n5_12 n6_12 0.5
I5_12 n5_12 0 DC 50u
RH5_13 n5_13 n5_14 0.5
RV5_13 n5_13 n6_13 0.5
I5_13 n5_13 0 DC 50u
RH5_14 n5_14 n5_15 0.5
RV5_14 n5_14 n6_14 0.5
I5_14 n5_14 0 DC 50u
RV5_15 n5_15 n6_15 0.5
I5_15 n5_15 0 DC 50u
RH6_0 n6_0 n6_1 0.5
RV6_0 n6_0 n7_0 0.5
I6_0 n6_0 0 DC 50u
RH6_1 n6_1 n6_2 0.5
RV6_1 n6_1 n7_1 0.5
I6_1 n6_1 0 DC 50u
RH6_2 n6_2 n6_3 0.5
RV6_2 n6_2 n7_2 0.5
I6_2 n6_2 0 DC 50u
RH6_3 n6_3 n6_4 0.5
RV6_3 n6_3 n7_3 0.5
I6_3 n6_3 0 DC 50u
RH6_4 n6_4 n6_5 0.5
RV6_4 n6_4 n7_4 0.5
I6_4 n6_4 0 DC 50u
RH6_5 n6_5 n6_6 0.5
RV6_5 n6_5 n7_5 0.5
I6_5 n6_5 0 DC 50u
RH6_6 n6_6 n6_7 0.5
RV6_6 n6_6 n7_6 0.5
I6_6 n6_6 0 DC 50u
RH6_7 n6_7 n6_8 0.5
RV6_7 n6_7 n7_7 0.5
I6_7 n6_7 0 DC 50u
RH6_8 n6_8 n6_9 0.5
RV6_8 n6_8 n7_8 0.5
I6_8 n6_8 0 DC 50u
RH6_9 n6_9 n6_10 0.5
RV6_9 n6_9 n7_9 0.5
I6_9 n6_9 0 DC 50u
RH6_10 n6_10 n6_11 0.5
RV6_10 n6_10 n7_10 0.5
I6_10 n6_10 0 DC 50u
RH6_11 n6_11 n6_12 0.5
RV6_11 n6_11 n7_11 0.5
I6_11 n6_11 0 DC 50u
RH6_12 n6_12 n6_13 0.5
RV6_12 n6_12 n7_12 0.5
I6_12 n6_12 0 DC 50u
RH6_13 n6_13 n6_14 0.5
RV6_13 n6_13 n7_13 0.5
I6_13 n6_13 0 DC 50u
RH6_14 n6_14 n6_15 0.5
RV6_14 n6_14 n7_14 0.5
I6_14 n6_14 0 DC 50u
RV6_15 n6_15 n7_15 0.5
I6_15 n6_15 0 DC 50u
RH7_0 n7_0 n7_1 0.5
RV7_0 n7_0 n8_0 0.5
I7_0 n7_0 0 DC 50u
RH7_1 n7_1 n7_2 0.5
RV7_1 n7_1 n8_1 0.5
I7_1 n7_1 0 DC 50u
RH7_2 n7_2 n7_3 0.5
RV7_2 n7_2 n8_2 0.5
I7_2 n7_2 0 DC 50u
RH7_3 n7_3 n7_4 0.5
RV7_3 n7_3 n8_3 0.5
I7_3 n7_3 0 DC 50u
RH7_4 n7_4 n7_5 0.5
RV7_4 n7_4 n8_4 0.5
I7_4 n7_4 0 DC 50u
RH7_5 n7_5 n7_6 0.5
RV7_5 n7_5 n8_5 0.5
I7_5 n7_5 0 DC 50u
RH7_6 n7_6 n7_7 0.5
RV7_6 n7_6 n8_6 0.5
I7_6 n7_6 0 DC 50u
RH7_7 n7_7 n7_8 0.5
RV7_7 n7_7 n8_7 0.5
I7_7 n7_7 0 DC 50u
RH7_8 n7_8 n7_9 0.5
RV7_8 n7_8 n8_8 0.5
I7_8 n7_8 0 DC 50u
RH7_9 n7_9 n7_10 0.5
RV7_9 n7_9 n8_9 0.5
I7_9 n7_9 0 DC 50u
RH7_10 n7_10 n7_11 0.5
RV7_10 n7_10 n8_10 0.5
I7_10 n7_10 0 DC 50u
RH7_11 n7_11 n7_12 0.5
RV7_11 n7_11 n8_11 0.5
I7_11 n7_11 0 DC 50u
RH7_12 n7_12 n7_13 0.5
RV7_12 n7_12 n8_12 0.5
I7_12 n7_12 0 DC 50u
RH7_13 n7_13 n7_14 0.5
RV7_13 n7_13 n8_13 0.5
I7_13 n7_13 0 DC 50u
RH7_14 n7_14 n7_15 0.5
RV7_14 n7_14 n8_14 0.5
I7_14 n7_14 0 DC 50u
RV7_15 n7_15 n8_15 0.5
I7_15 n7_15 0 DC 50u
RH8_0 n8_0 n8_1 0.5
RV8_0 n8_0 n9_0 0.5
I8_0 n8_0 0 DC 50u
RH8_1 n8_1 n8_2 0.5
RV8_1 n8_1 n9_1 0.5
I8_1 n8_1 0 DC 50u
RH8_2 n8_2 n8_3 0.5
RV8_2 n8_2 n9_2 0.5
I8_2 n8_2 0 DC 50u
RH8_3 n8_3 n8_4 0.5
RV8_3 n8_3 n9_3 0.5
I8_3 n8_3 0 DC 50u
RH8_4 n8_4 n8_5 0.5
RV8_4 n8_4 n9_4 0.5
I8_4 n8_4 0 DC 50u
RH8_5 n8_5 n8_6 0.5
RV8_5 n8_5 n9_5 0.5
I8_5 n8_5 0 DC 50u
RH8_6 n8_6 n8_7 0.5
RV8_6 n8_6 n9_6 0.5
I8_6 n8_6 0 DC 50u
RH8_7 n8_7 n8_8 0.5
RV8_7 n8_7 n9_7 0.5
I8_7 n8_7 0 DC 50u
RH8_8 n8_8 n8_9 0.5
RV8_8 n8_8 n9_8 0.5
I8_8 n8_8 0 DC 50u
RH8_9 n8_9 n8_10 0.5
RV8_9 n8_9 n9_9 0.5
I8_9 n8_9 0 DC 50u
RH8_10 n8_10 n8_11 0.5
RV8_10 n8_10 n9_10 0.5
I8_10 n8_10 0 DC 50u
RH8_11 n8_11 n8_12 0.5
RV8_11 n8_11 n9_11 0.5
I8_11 n8_11 0 DC 50u
RH8_12 n8_12 n8_13 0.5
RV8_12 n8_12 n9_12 0.5
I8_12 n8_12 0 DC 50u
RH8_13 n8_13 n8_14 0.5
RV8_13 n8_13 n9_13 0.5
I8_13 n8_13 0 DC 50u
RH8_14 n8_14 n8_15 0.5
RV8_14 n8_14 n9_14 0.5
I8_14 n8_14 0 DC 50u
RV8_15 n8_15 n9_15 0.5
I8_15 n8_15 0 DC 50u
RH9_0 n9_0 n9_1 0.5
RV9_0 n9_0 n10_0 0.5
I9_0 n9_0 0 DC 50u
RH9_1 n9_1 n9_2 0.5
RV9_1 n9_1 n10_1 0.5
I9_1 n9_1 0 DC 50u
RH9_2 n9_2 n9_3 0.5
RV9_2 n9_2 n10_2 0.5
I9_2 n9_2 0 DC 50u
RH9_3 n9_3 n9_4 0.5
RV9_3 n9_3 n10_3 0.5
I9_3 n9_3 0 DC 50u
RH9_4 n9_4 n9_5 0.5
RV9_4 n9_4 n10_4 0.5
I9_4 n9_4 0 DC 50u
RH9_5 n9_5 n9_6 0.5
RV9_5 n9_5 n10_5 0.5
I9_5 n9_5 0 DC 50u
RH9_6 n9_6 n9_7 0.5
RV9_6 n9_6 n10_6 0.5
I9_6 n9_6 0 DC 50u
RH9_7 n9_7 n9_8 0.5
RV9_7 n9_7 n10_7 0.5
I9_7 n9_7 0 DC 50u
RH9_8 n9_8 n9_9 0.5
RV9_8 n9_8 n10_8 0.5
I9_8 n9_8 0 DC 50u
RH9_9 n9_9 n9_10 0.5
RV9_9 n9_9 n10_9 0.5
I9_9 n9_9 0 DC 50u
RH9_10 n9_10 n9_11 0.5
RV9_10 n9_10 n10_10 0.5
I9_10 n9_10 0 DC 50u
RH9_11 n9_11 n9_12 0.5
RV9_11 n9_11 n10_11 0.5
I9_11 n9_11 0 DC 50u
RH9_12 n9_12 n9_13 0.5
RV9_12 n9_12 n10_12 0.5
I9_12 n9_12 0 DC 50u
RH9_13 n9_13 n9_14 0.5
RV9_13 n9_13 n10_13 0.5
I9_13 n9_13 0 DC 50u
RH9_14 n9_14 n9_15 0.5
RV9_14 n9_14 n10_14 0.5
I9_14 n9_14 0 DC 50u
RV9_15 n9_15 n10_15 0.5
I9_15 n9_15 0 DC 50u
RH10_0 n10_0 n10_1 0.5
RV10_0 n10_0 n11_0 0.5
I10_0 n10_0 0 DC 50u
RH10_1 n10_1 n10_2 0.5
RV10_1 n10_1 n11_1 0.5
I10_1 n10_1 0 DC 50u
RH10_2 n10_2 n10_3 0.5
RV10_2 n10_2 n11_2 0.5
I10_2 n10_2 0 DC 50u
RH10_3 n10_3 n10_4 0.5
RV10_3 n10_3 n11_3 0.5
I10_3 n10_3 0 DC 50u
RH10_4 n10_4 n10_5 0.5
RV10_4 n10_4 n11_4 0.5
I10_4 n10_4 0 DC 50u
RH10_5 n10_5 n10_6 0.5
RV10_5 n10_5 n11_5 0.5
I10_5 n10_5 0 DC 50u
RH10_6 n10_6 n10_7 0.5
RV10_6 n10_6 n11_6 0.5
I10_6 n10_6 0 DC 50u
RH10_7 n10_7 n10_8 0.5
RV10_7 n10_7 n11_7 0.5
I10_7 n10_7 0 DC 50u
RH10_8 n10_8 n10_9 0.5
RV10_8 n10_8 n11_8 0.5
I10_8 n10_8 0 DC 50u
RH10_9 n10_9 n10_10 0.5
RV10_9 n10_9 n11_9 0.5
I10_9 n10_9 0 DC 50u
RH10_10 n10_10 n10_11 0.5
RV10_10 n10_10 n11_10 0.5
I10_10 n10_10 0 DC 50u
RH10_11 n10_11 n10_12 0.5
RV10_11 n10_11 n11_11 0.5
I10_11 n10_11 0 DC 50u
RH10_12 n10_12 n10_13 0.5
RV10_12 n10_12 n11_12 0.5
I10_12 n10_12 0 DC 50u
RH10_13 n10_13 n10_14 0.5
RV10_13 n10_13 n11_13 0.5
I10_13 n10_13 0 DC 50u
RH10_14 n10_14 n10_15 0.5
RV10_14 n10_14 n11_14 0.5
I10_14 n10_14 0 DC 50u
RV10_15 n10_15 n11_15 0.5
I10_15 n10_15 0 DC 50u
RH11_0 n11_0 n11_1 0.5
RV11_0 n11_0 n12_0 0.5
I11_0 n11_0 0 DC 50u
RH11_1 n11_1 n11_2 0.5
RV11_1 n11_1 n12_1 0.5
I11_1 n11_1 0 DC 50u
RH11_2 n11_2 n11_3 0.5
RV11_2 n11_2 n12_2 0.5
I11_2 n11_2 0 DC 50u
RH11_3 n11_3 n11_4 0.5
RV11_3 n11_3 n12_3 0.5
I11_3 n11_3 0 DC 50u
RH11_4 n11_4 n11_5 0.5
RV11_4 n11_4 n12_4 0.5
I11_4 n11_4 0 DC 50u
RH11_5 n11_5 n11_6 0.5
RV11_5 n11_5 n12_5 0.5
I11_5 n11_5 0 DC 50u
RH11_6 n11_6 n11_7 0.5
RV11_6 n11_6 n12_6 0.5
I11_6 n11_6 0 DC 50u
RH11_7 n11_7 n11_8 0.5
RV11_7 n11_7 n12_7 0.5
I11_7 n11_7 0 DC 50u
RH11_8 n11_8 n11_9 0.5
RV11_8 n11_8 n12_8 0.5
I11_8 n11_8 0 DC 50u
RH11_9 n11_9 n11_10 0.5
RV11_9 n11_9 n12_9 0.5
I11_9 n11_9 0 DC 50u
RH11_10 n11_10 n11_11 0.5
RV11_10 n11_10 n12_10 0.5
I11_10 n11_10 0 DC 50u
RH11_11 n11_11 n11_12 0.5
RV11_11 n11_11 n12_11 0.5
I11_11 n11_11 0 DC 50u
RH11_12 n11_12 n11_13 0.5
RV11_12 n11_12 n12_12 0.5
I11_12 n11_12 0 DC 50u
RH11_13 n11_13 n11_14 0.5
RV11_13 n11_13 n12_13 0.5
I11_13 n11_13 0 DC 50u
RH11_14 n11_14 n11_15 0.5
RV11_14 n11_14 n12_14 0.5
I11_14 n11_14 0 DC 50u
RV11_15 n11_15 n12_15 0.5
I11_15 n11_15 0 DC 50u
RH12_0 n12_0 n12_1 0.5
RV12_0 n12_0 n13_0 0.5
I12_0 n12_0 0 DC 50u
RH12_1 n12_1 n12_2 0.5
RV12_1 n12_1 n13_1 0.5
I12_1 n12_1 0 DC 50u
RH12_2 n12_2 n12_3 0.5
RV12_2 n12_2 n13_2 0.5
I12_2 n12_2 0 DC 50u
RH12_3 n12_3 n12_4 0.5
RV12_3 n12_3 n13_3 0.5
I12_3 n12_3 0 DC 50u
RH12_4 n12_4 n12_5 0.5
RV12_4 n12_4 n13_4 0.5
I12_4 n12_4 0 DC 50u
RH12_5 n12_5 n12_6 0.5
RV12_5 n12_5 n13_5 0.5
I12_5 n12_5 0 DC 50u
RH12_6 n12_6 n12_7 0.5
RV12_6 n12_6 n13_6 0.5
I12_6 n12_6 0 DC 50u
RH12_7 n12_7 n12_8 0.5
RV12_7 n12_7 n13_7 0.5
I12_7 n12_7 0 DC 50u
RH12_8 n12_8 n12_9 0.5
RV12_8 n12_8 n13_8 0.5
I12_8 n12_8 0 DC 50u
RH12_9 n12_9 n12_10 0.5
RV12_9 n12_9 n13_9 0.5
I12_9 n12_9 0 DC 50u
RH12_10 n12_10 n12_11 0.5
RV12_10 n12_10 n13_10 0.5
I12_10 n12_10 0 DC 50u
RH12_11 n12_11 n12_12 0.5
RV12_11 n12_11 n13_11 0.5
I12_11 n12_11 0 DC 50u
RH12_12 n12_12 n12_13 0.5
RV12_12 n12_12 n13_12 0.5
I12_12 n12_12 0 DC 50u
RH12_13 n12_13 n12_14 0.5
RV12_13 n12_13 n13_13 0.5
I12_13 n12_13 0 DC 50u
RH12_14 n12_14 n12_15 0.5
RV12_14 n12_14 n13_14 0.5
I12_14 n12_14 0 DC 50u
RV12_15 n12_15 n13_15 0.5
I12_15 n12_15 0 DC 50u
RH13_0 n13_0 n13_1 0.5
RV13_0 n13_0 n14_0 0.5
I13_0 n13_0 0 DC 50u
RH13_1 n13_1 n13_2 0.5
RV13_1 n13_1 n14_1 0.5
I13_1 n13_1 0 DC 50u
RH13_2 n13_2 n13_3 0.5
RV13_2 n13_2 n14_2 0.5
I13_2 n13_2 0 DC 50u
RH13_3 n13_3 n13_4 0.5
RV13_3 n13_3 n14_3 0.5
I13_3 n13_3 0 DC 50u
RH13_4 n13_4 n13_5 0.5
RV13_4 n13_4 n14_4 0.5
I13_4 n13_4 0 DC 50u
RH13_5 n13_5 n13_6 0.5
RV13_5 n13_5 n14_5 0.5
I13_5 n13_5 0 DC 50u
RH13_6 n13_6 n13_7 0.5
RV13_6 n13_6 n14_6 0.5
I13_6 n13_6 0 DC 50u
RH13_7 n13_7 n13_8 0.5
RV13_7 n13_7 n14_7 0.5
I13_7 n13_7 0 DC 50u
RH13_8 n13_8 n13_9 0.5
RV13_8 n13_8 n14_8 0.5
I13_8 n13_8 0 DC 50u
RH13_9 n13_9 n13_10 0.5
RV13_9 n13_9 n14_9 0.5
I13_9 n13_9 0 DC 50u
RH13_10 n13_10 n13_11 0.5
RV13_10 n13_10 n14_10 0.5
I13_10 n13_10 0 DC 50u
RH13_11 n13_11 n13_12 0.5
RV13_11 n13_11 n14_11 0.5
I13_11 n13_11 0 DC 50u
RH13_12 n13_12 n13_13 0.5
RV13_12 n13_12 n14_12 0.5
I13_12 n13_12 0 DC 50u
RH13_13 n13_13 n13_14 0.5
RV13_13 n13_13 n14_13 0.5
I13_13 n13_13 0 DC 50u
RH13_14 n13_14 n13_15 0.5
RV13_14 n13_14 n14_14 0.5
I13_14 n13_14 0 DC 50u
RV13_15 n13_15 n14_15 0.5
I13_15 n13_15 0 DC 50u
RH14_0 n14_0 n14_1 0.5
RV14_0 n14_0 n15_0 0.5
I14_0 n14_0 0 DC 50u
RH14_1 n14_1 n14_2 0.5
RV14_1 n14_1 n15_1 0.5
I14_1 n14_1 0 DC 50u
RH14_2 n14_2 n14_3 0.5
RV14_2 n14_2 n15_2 0.5
I14_2 n14_2 0 DC 50u
RH14_3 n14_3 n14_4 0.5
RV14_3 n14_3 n15_3 0.5
I14_3 n14_3 0 DC 50u
RH14_4 n14_4 n14_5 0.5
RV14_4 n14_4 n15_4 0.5
I14_4 n14_4 0 DC 50u
RH14_5 n14_5 n14_6 0.5
RV14_5 n14_5 n15_5 0.5
I14_5 n14_5 0 DC 50u
RH14_6 n14_6 n14_7 0.5
RV14_6 n14_6 n15_6 0.5
I14_6 n14_6 0 DC 50u
RH14_7 n14_7 n14_8 0.5
RV14_7 n14_7 n15_7 0.5
I14_7 n14_7 0 DC 50u
RH14_8 n14_8 n14_9 0.5
RV14_8 n14_8 n15_8 0.5
I14_8 n14_8 0 DC 50u
RH14_9 n14_9 n14_10 0.5
RV14_9 n14_9 n15_9 0.5
I14_9 n14_9 0 DC 50u
RH14_10 n14_10 n14_11 0.5
RV14_10 n14_10 n15_10 0.5
I14_10 n14_10 0 DC 50u
RH14_11 n14_11 n14_12 0.5
RV14_11 n14_11 n15_11 0.5
I14_11 n14_11 0 DC 50u
RH14_12 n14_12 n14_13 0.5
RV14_12 n14_12 n15_12 0.5
I14_12 n14_12 0 DC 50u
RH14_13 n14_13 n14_14 0.5
RV14_13 n14_13 n15_13 0.5
I14_13 n14_13 0 DC 50u
RH14_14 n14_14 n14_15 0.5
RV14_14 n14_14 n15_14 0.5
I14_14 n14_14 0 DC 50u
RV14_15 n14_15 n15_15 0.5
I14_15 n14_15 0 DC 50u
RH15_0 n15_0 n15_1 0.5
I15_0 n15_0 0 DC 50u
RH15_1 n15_1 n15_2 0.5
I15_1 n15_1 0 DC 50u
RH15_2 n15_2 n15_3 0.5
I15_2 n15_2 0 DC 50u
RH15_3 n15_3 n15_4 0.5
I15_3 n15_3 0 DC 50u
RH15_4 n15_4 n15_5 0.5
I15_4 n15_4 0 DC 50u
RH15_5 n15_5 n15_6 0.5
I15_5 n15_5 0 DC 50u
RH15_6 n15_6 n15_7 0.5
I15_6 n15_6 0 DC 50u
RH15_7 n15_7 n15_8 0.5
I15_7 n15_7 0 DC 50u
RH15_8 n15_8 n15_9 0.5
I15_8 n15_8 0 DC 50u
RH15_9 n15_9 n15_10 0.5
I15_9 n15_9 0 DC 50u
RH15_10 n15_10 n15_11 0.5
I15_10 n15_10 0 DC 50u
RH15_11 n15_11 n15_12 0.5
I15_11 n15_11 0 DC 50u
RH15_12 n15_12 n15_13 0.5
I15_12 n15_12 0 DC 50u
RH15_13 n15_13 n15_14 0.5
I15_13 n15_13 0 DC 50u
RH15_14 n15_14 n15_15 0.5
I15_14 n15_14 0 DC 50u
I15_15 n15_15 0 DC 50u
.probe v(n0_0) v(n8_8) v(n15_5)
.op
